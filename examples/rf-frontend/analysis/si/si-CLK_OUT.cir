* anvil SI /CLK_OUT
Vsrc src 0 PULSE(0 3.3 0 1e-09 1e-09 1 2)
Rsrc src n1 50
T0 n1 0 n3 0 Z0=49.7491 TD=3.2617e-11
T1 n3 0 n2 0 Z0=49.7491 TD=4.74402e-11
Vterm vterm 0 DC 0
Crx0 n2 0 1e-12
Rterm0 n2 vterm 50
.tran 5e-12 1.6e-08 0 5e-12
.end
